
addrmap top {
    reg {
        field {
            hw=r; sw=rw;
        } y = 0;
    } whee[2][8];

    reg {
        field {
            hw=w; sw=rw;
        } matt_field;
    } matt_reg;

    regfile {
        reg {
            field {
                hw=r; sw=rw;
            } abc1[16:2] = 0;
            field {
                hw=r; sw=rw;
            } def1[4] = 0;
        } aaa[4];
        reg {
            field {
                hw=w; sw=r;
            } abc2 = 0;
            field {
                hw=r; sw=rw;
            } def2 = 0;
        } bbb;
    } asdf[20];
};
