
addrmap top {

    reg {
        field {
            singlepulse;
        } matt_field = 0;
    } matt_reg;
};
